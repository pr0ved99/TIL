.title KiCad schematic
.ac dec 200 1 1Meg
C1 /VADC 0 100n
R1 /VIN /VADC 12k
V1 /VIN 0 DC 1.65 SIN( 1.65 100m 19k 0 0 0 ) AC 1
.end
