.title KiCad schematic
R3 /VDIV 0 4.747k
R4 /VADC /VDIV 1k
R1 /VRAIL Net-_R1-Pad2_ 11.88k
R2 Net-_R1-Pad2_ /VDIV 11.88k
C1 /VDIV 0 100n
V1 /VRAIL 0 DC 16 AC 1 0
.end
