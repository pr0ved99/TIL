.title KiCad schematic
.model __S1 SW
+           vt=1.65
+           ron=2
+           roff=1G
C1 /VDIV 0 100n
R3 /VDIV 0 4.7k
R4 Net-_S1-N+_ /VDIV 1k
R2 Net-_R1-Pad2_ /VDIV 12k
R1 /VRAIL Net-_R1-Pad2_ 12k
S1 Net-_S1-N+_ /VADC /VCTRL 0 __S1
V1 /VRAIL 0 DC 16 AC 1 0
R5 /VADC 0 47k
B1 /VCTRL 0 v=V(/VDDA) > 3 ? V(/VDDA) : 0
V3 /VDDA 0 PWL( 0 3.3 10m 3.3 13.3m 0 15m 0 )
C2 /VADC 0 100p
.end
