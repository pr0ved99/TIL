.title KiCad schematic
.model __S1 SW
+           vt=1.65
+           ron=2
+           roff=1G
R5 /VADC 0 47k
V3 /VDDA 0 PWL( 0 3.3 10 3.3 )
V4 /VNOISE 0 TRRANDOM( 2 500u 250u 3m 0 )
B3 /VRAW_BIAS 0 v=V(/VRAW)+0.005
B1 /VCTRL 0 v=V(/VDDA) > 3 ? V(/VDDA) : 0
C2 /VADC 0 100p
B2 /VRAW 0 v=V(/VADC)+V(/VNOISE)
C1 /VDIV 0 100n
S1 Net-_S1-N+_ /VADC /VCTRL 0 __S1
R1 /VRAIL Net-_R1-Pad2_ 12k
R2 Net-_R1-Pad2_ /VDIV 12k
V1 /VRAIL 0 PWL( 0 12 10 12 )
R4 Net-_S1-N+_ /VDIV 1k
R3 /VDIV 0 4.7k
.end
